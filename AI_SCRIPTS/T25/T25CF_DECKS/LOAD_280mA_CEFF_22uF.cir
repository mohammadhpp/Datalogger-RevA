T25CF TPS54202 USB ONLY - NO BOARD PASS
* Effective capacitors and source waveform are declared sensitivity fixtures.
* Do not connect this 3.576V rail to USB_5V_AUX.
.LIB "TPS54202_TRANS.LIB"
V_SRC SRC 0 PWL(0 0 1u 5 15m 5 15.001m 12 20m 12 20.001m 5.5 28m 5.5)
R_SOURCE SRC USB_SRC 0.1
V_CONNECT CONNECT 0 PWL(0 0 1u 1 24.999m 1 25m 0 28m 0)
S_CABLE USB_SRC VIN CONNECT 0 CABLE_SW
.MODEL CABLE_SW VSWITCH(RON=0.01 ROFF=1G VON=0.9 VOFF=0.1)
* Cable unplug OPENS the source; it does not short VIN to zero.
R_CIN VIN CIN 0.005
C_CIN CIN 0 22u
R_LEAK VIN 0 1G
X_USB 0 PH VIN FB EN BOOT TPS54202_TRANS PARAMS: STEADY_STATE=0
* EN left floating per TI; never tied to raw 12V.
C_BOOT BOOT PH 100n
L_USB PH LX 10u
R_DCR LX VOUT 0.029
R_COUT VOUT COUT 0.005
C_COUT COUT 0 22u
R_TOP VOUT FB 100k
R_BOTTOM1 FB FBMID 10k
R_BOTTOM2 FBMID 0 10k
C_FF VOUT FB 56p
R_LOAD VOUT 0 10.3796883117
.TRAN 2u 28m 0 20n
.OPTIONS ABSTOL=10n VNTOL=10u ITL1=1500 ITL2=400 ITL4=100
.PROBE64 V([VIN]) V([VOUT]) V([EN]) V([FB]) I(L_USB) I(V_SRC)
.PRINT TRAN V([VIN]) V([VOUT]) V([EN]) I(L_USB) I(V_SRC)
.END
